; ============================================================
; Batch OCEAN script
; Cartesian product over all st_1 and st_2 PWL files
;
; For every:
;     st_1/<freq>/<trial>.pwl
; and every:
;     st_2/<freq>/<trial>.pwl
;
; run one simulation and export:
;     i("/I172/Iout")
;     i("/I56/Iout")
;     v("/vpre")
;     v("/vpre1")
;
; By default, delete the PSF directory after exporting the text file.
; ============================================================

simulator('spectre)

; ------------------------------------------------------------
; Design under test
; ------------------------------------------------------------

design("sebastian_thesis_pilot" "dynapsetb1" "schematic")

; ------------------------------------------------------------
; User options
; ------------------------------------------------------------

; Set to t if you want to keep the full PSF simulation database.
; Set to nil if you only want output_signals.txt.
keepPsf = nil

; ------------------------------------------------------------
; Base directories
; ------------------------------------------------------------

baseRepoDir = "/home/s5117909/Documents/thesis/sebastian_thesis_repo"

pwlBaseDir = strcat(baseRepoDir "/processing/general_code/spike_train_output")

st1BaseDir = strcat(pwlBaseDir "/st_1")
st2BaseDir = strcat(pwlBaseDir "/st_2")

outputBaseDir = strcat(baseRepoDir "/processing/cadence_extraction/output_data")

unless(isDir(outputBaseDir)
    system(strcat("mkdir -p " outputBaseDir))
)

; ------------------------------------------------------------
; Analysis
; ------------------------------------------------------------

analysis('tran ?stop "1s")

; ------------------------------------------------------------
; Define ordinary design variables
; ------------------------------------------------------------

desVar("ml" 180n)
desVar("mw" 180n)

desVar("m2l"   180n)
desVar("m2ltb" 180n)
desVar("m2w"   180n)
desVar("m2wtb" 180n)

desVar("m3l" 180n)
desVar("m3w" 180n)

desVar("m4l"   180n)
desVar("m4ltb" 180n)
desVar("m4w"   180n)
desVar("m4wtb" 180n)

desVar("m5l" 180n)
desVar("m5w" 180n)

desVar("pw"   100u)
desVar("T"    1m)
desVar("Vin"  0)
desVar("Vtau" 1.6)
desVar("Vthr" 0.9)
desVar("Vw"   0.5)
desVar("vmax" 1.8)

; ------------------------------------------------------------
; Save requested currents and voltages
; ------------------------------------------------------------

save('i "/I172/Iout")
save('i "/I56/Iout")

save('v "/vpre")
save('v "/vpre1")

; ------------------------------------------------------------
; Manifest file
; ------------------------------------------------------------

manifestPath = strcat(outputBaseDir "/run_manifest.csv")
manifestPort = outfile(manifestPath "w")

fprintf(
    manifestPort
    "run_name,st1_frequency,st1_trial,st1_file,st2_frequency,st2_trial,st2_file,run_dir,keep_psf\n"
)

; ------------------------------------------------------------
; Basic sanity checks
; ------------------------------------------------------------

unless(isDir(st1BaseDir)
    error("Cannot find st_1 directory: %s\n" st1BaseDir)
)

unless(isDir(st2BaseDir)
    error("Cannot find st_2 directory: %s\n" st2BaseDir)
)

; ------------------------------------------------------------
; Main Cartesian-product batch loop
; ------------------------------------------------------------

st1FreqDirs = getDirFiles(st1BaseDir)
st2FreqDirs = getDirFiles(st2BaseDir)

runCount = 0

foreach(st1FreqDirName st1FreqDirs

    when(st1FreqDirName != "." && st1FreqDirName != ".."

        st1FreqDir = strcat(st1BaseDir "/" st1FreqDirName)

        when(isDir(st1FreqDir)

            st1TrialFiles = getDirFiles(st1FreqDir)

            foreach(st1TrialFile st1TrialFiles

                when(rexMatchp("\\.pwl$" st1TrialFile)

                    st1File = strcat(st1FreqDir "/" st1TrialFile)

                    when(isFile(st1File)

                        ; Remove ".pwl" from st_1 trial filename.
                        st1TrialStem = substring(
                            st1TrialFile
                            1
                            difference(strlen(st1TrialFile) 4)
                        )

                        ; ------------------------------------------------
                        ; Inner loop over all st_2 frequency/trial files
                        ; ------------------------------------------------

                        foreach(st2FreqDirName st2FreqDirs

                            when(st2FreqDirName != "." && st2FreqDirName != ".."

                                st2FreqDir = strcat(st2BaseDir "/" st2FreqDirName)

                                when(isDir(st2FreqDir)

                                    st2TrialFiles = getDirFiles(st2FreqDir)

                                    foreach(st2TrialFile st2TrialFiles

                                        when(rexMatchp("\\.pwl$" st2TrialFile)

                                            st2File = strcat(st2FreqDir "/" st2TrialFile)

                                            when(isFile(st2File)

                                                ; Remove ".pwl" from st_2 trial filename.
                                                st2TrialStem = substring(
                                                    st2TrialFile
                                                    1
                                                    difference(strlen(st2TrialFile) 4)
                                                )

                                                runCount = runCount + 1

                                                ; Example:
                                                ; st1_10_hz_trial_3__st2_100_hz_trial_1
                                                runName = strcat(
                                                    "st1_"
                                                    st1FreqDirName
                                                    "_"
                                                    st1TrialStem
                                                    "__st2_"
                                                    st2FreqDirName
                                                    "_"
                                                    st2TrialStem
                                                )

                                                runDir = strcat(outputBaseDir "/" runName)

                                                unless(isDir(runDir)
                                                    system(strcat("mkdir -p " runDir))
                                                )

                                                ; Send Spectre result database to this run-specific directory.
                                                resultsDir(runDir)

                                                ; ------------------------------------------------
                                                ; Set PWL-file design variables
                                                ; ------------------------------------------------
                                                ; Important:
                                                ; File paths need embedded quotation marks so Spectre
                                                ; receives them as string parameters.

                                                desVar("pwlFile_st1" strcat("\"" st1File "\""))
                                                desVar("pwlFile_st2" strcat("\"" st2File "\""))

                                                printf("============================================================\n")
                                                printf("Run %d: %s\n" runCount runName)
                                                printf("  st_1 PWL: %s\n" st1File)
                                                printf("  st_2 PWL: %s\n" st2File)
                                                printf("  output:   %s\n" runDir)
                                                printf("  keepPsf:  %L\n" keepPsf)

                                                fprintf(
                                                    manifestPort
                                                    "%s,%s,%s,%s,%s,%s,%s,%s,%L\n"
                                                    runName
                                                    st1FreqDirName
                                                    st1TrialFile
                                                    st1File
                                                    st2FreqDirName
                                                    st2TrialFile
                                                    st2File
                                                    runDir
                                                    keepPsf
                                                )

                                                ; ------------------------------------------------
                                                ; Run simulation
                                                ; ------------------------------------------------

                                                run()

                                                ; ------------------------------------------------
                                                ; Export current and voltage waveforms
                                                ; ------------------------------------------------

                                                selectResult('tran)

                                                iout_172 = i("/I172/Iout")
                                                iout_56  = i("/I56/Iout")

                                                vpre  = v("/vpre")
                                                vpre1 = v("/vpre1")

                                                ocnPrint(
                                                    ?output strcat(runDir "/output_signals.txt")
                                                    ?precision 10
                                                    ?numSpaces 1
                                                    iout_172
                                                    iout_56
                                                    vpre
                                                    vpre1
                                                )

                                                ; ------------------------------------------------
                                                ; Optionally delete PSF data
                                                ; ------------------------------------------------
                                                ; PSF is needed temporarily for ocnPrint().
                                                ; After output_signals.txt is written, it can be
                                                ; deleted to reduce storage and transfer time.

                                                unless(keepPsf

                                                    psfDir = strcat(runDir "/psf")

                                                    when(isDir(psfDir)
                                                        printf("Deleting PSF directory: %s\n" psfDir)
                                                        system(strcat("rm -rf " psfDir))
                                                    )
                                                )

                                                printf("Finished: %s\n" runName)
                                            )
                                        )
                                    )
                                )
                            )
                        )
                    )
                )
            )
        )
    )
)

close(manifestPort)

printf("============================================================\n")
printf("Finished all Cartesian-product batch simulations.\n")
printf("Total runs: %d\n" runCount)
printf("Manifest written to: %s\n" manifestPath)
printf("Output base directory: %s\n" outputBaseDir)
printf("keepPsf = %L\n" keepPsf)
printf("============================================================\n")
