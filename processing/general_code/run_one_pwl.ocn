; ============================================================
; Minimal OCEAN test script
; ============================================================

simulator('spectre)

; Replace these with your actual library, cell, and view names.
design("YOUR_LIB_NAME" "YOUR_CELL_NAME" "schematic")

; Choose your analysis.
analysis('tran ?stop "1s")

; Set the two PWL file design variables.
desVar("pwlFile_st1" "/home/eric/processing/general_code/spike_train_output/st_1/92_hz/trial_1.pwl")
desVar("pwlFile_st2" "/home/eric/processing/general_code/spike_train_output/st_2/92_hz/trial_1.pwl")

; Save whatever signals you care about.
; save('v "/out")
; save('v "/some_internal_node")

; Run.
run()
